// Copyright 2025 KU Leuven.
// Licensed under the Apache License, Version 2.0, see LICENSE for details.
// SPDX-License-Identifier: Apache-2.0

// Author: Jiacong Sun <jiacong.sun@kuleuven.be>

{
  name: "lagd_core"
  clock_primary: "clk_i"
  bus_interfaces: [
    { protocol: "reg_iface", direction: "device" }
  ],
  regwidth: 32
  registers: [

    { name:     "global_cfg_1"
      desc:     "Global configuration signals 1"
      swaccess: "rw"
      hwaccess: "hro"
      fields: [
        { bits: "0",     resval: "0",  name: "flush_en",                    desc: "Whether to flush data"                                  }
        { bits: "1",     resval: "1",  name: "en_aw",                       desc: "Whether to enable the analog macro wrap"                }
        { bits: "2",     resval: "1",  name: "en_em",                       desc: "Whether to enable the energy monitor"                   }
        { bits: "3",     resval: "1",  name: "en_fm",                       desc: "Whether to enable the flip manager"                     }
        { bits: "4",     resval: "1",  name: "en_ff",                       desc: "Whether to enable the flip filter"                      }
        { bits: "5",     resval: "1",  name: "en_ef",                       desc: "Whether to enable the energy monitor fifo"              }
        { bits: "6",     resval: "1",  name: "en_analog_loop",              desc: "Whether to include analog in the loop"                  }
        { bits: "7",     resval: "1",  name: "en_comparison",               desc: "Whether to enable energy comparison"                    }
        { bits: "8",     resval: "0",  name: "debug_dt_configure_enable",   desc: "Whether to enable configuration for debug dt module"    }
        { bits: "9",     resval: "0",  name: "debug_spin_configure_enable", desc: "Whether to enable configuration for debug spin module"  }
        { bits: "10",    resval: "0",  name: "en_perf_counter",             desc: "Whether to enable performance counter"                  }
        { bits: "11",    resval: "0",  name: "bypass_data_conversion",      desc: "Whether to skip analog data conversion"                 }
        { bits: "12",    resval: "0",  name: "host_readout",                desc: "Whether to read spins from spin pop interface"          }
        { bits: "13",    resval: "0",  name: "flip_disable",                desc: "Whether to disable applying flip icons"                 }
        { bits: "14",    resval: "1",  name: "enable_flip_detection",       desc: "Whether to enable flip detection"                       }
        { bits: "15",    resval: "0",  name: "debug_j_write_en",            desc: "Whether to enable debug J writing mode"                 }
        { bits: "16",    resval: "0",  name: "debug_j_read_en",             desc: "Whether to enable debug J reading mode"                 }
        { bits: "17",    resval: "0",  name: "debug_spin_write_en",         desc: "Whether to enable debug spin writing mode"              }
        { bits: "18",    resval: "0",  name: "debug_spin_compute_en",       desc: "Whether to enable debug spin computing mode"            }
        { bits: "19",    resval: "0",  name: "debug_spin_read_en",          desc: "Whether to enable debug spin reading mode"              }
        { bits: "27:20", resval: "0",  name: "config_counter",              desc: "Number of spins"                                        }
        { bits: "28",    resval: "1",  name: "wwl_vdd_cfg_256",             desc: "wwl_vdd_cfg [256]"                                      }
        { bits: "29",    resval: "0",  name: "wwl_vread_cfg_256",           desc: "wwl_vread_cfg [256]"                                    }
        { bits: "31:30", resval: "3",  name: "synchronizer_wbl_pipe_num",   desc: "Selected synchronizer num for wbl read"                 }
      ]
    }

    { name:     "global_cfg_2"
      desc:     "Global configuration signals 2"
      swaccess: "rw"
      hwaccess: "hro"
      fields: [
        { bits: "0",     resval: "0",  name: "cmpt_en",                     desc: "Whether to start computation"                           }
        { bits: "1",     resval: "0",  name: "config_valid_aw",             desc: "Whether to enable configuration for analog wrap"        }
        { bits: "2",     resval: "0",  name: "config_valid_em",             desc: "Whether to enable configuration for energy monitor"     }
        { bits: "3",     resval: "0",  name: "config_valid_fm",             desc: "Whether to enable configuration for flip manager"       }
        { bits: "4",     resval: "0",  name: "dt_cfg_enable",               desc: "Whether to start analog weight onloading"               }
        { bits: "6:5",   resval: "3",  name: "synchronizer_pipe_num",       desc: "Selected synchronizer num"                              }
        { bits: "7",     resval: "0",  name: "debug_h_wwl",                 desc: "h_wwl in debug dt write/read mode"                      }
        { bits: "13:8",  resval: "63", name: "dgt_addr_upper_bound",        desc: "J address upper bound (inclusive)"                      }
        { bits: "14",    resval: "0",  name: "ctnus_fifo_read",             desc: "Whether to read energy/spin fifo continuously"          }
        { bits: "15",    resval: "0",  name: "ctnus_dgt_debug",             desc: "Whether to enable digital debugging logic continuously" }
        { bits: "16",    resval: "0",  name: "infinite_icon_loop_en",       desc: "Whether to never stop cmpt after it starts"             }
        { bits: "17",    resval: "0",  name: "multi_cmpt_mode_en",          desc: "Whether to repeat the computation multiple times with the same configuration  (for power measurement purpose)"}
        { bits: "18",    resval: "0",  name: "config_spin_initial_skip_0",  desc: "Whether to skip current spin initial value, set 0"      }
        { bits: "19",    resval: "0",  name: "config_spin_initial_skip_1",  desc: "Whether to skip current spin initial value, set 1"      }
      ]
    }

    { name:     "cmpt_max_num"
      desc:     "Computation max number configuration under multi_cmpt_mode"
      swaccess: "rw"
      hwaccess: "hro"
      fields: [
        { bits: "31:0",  resval: "0xFFFFFFFF",   name: "cmpt_max_num",              desc: "cmpt_max_num value"                             }
      ]
    }

    { multireg:
      { name:     "config_spin_initial_0"
        desc:     "Registers for setting initial spin values, set 0"
        swaccess: "rw"
        hwaccess: "hro"
        count:    "8"
        cname:    "config_spin_initial_0"
        fields: [
          { bits: "31:0", resval: "0",           name: "config_spin_initial_0",      desc: "Registers for setting initial spin values, set 0"}
        ]
      }
    }

    { multireg:
      { name:     "config_spin_initial_1"
        desc:     "Registers for setting initial spin values, set 1"
        swaccess: "rw"
        hwaccess: "hro"
        count:    "8"
        cname:    "config_spin_initial_1"
        fields: [
          { bits: "31:0", resval: "0",           name: "config_spin_initial_1",      desc: "Registers for setting initial spin values, set 1"}
        ]
      }
    }

    { name:     "counter_cfg_1"
      desc:     "Registers for counter configuration 1"
      swaccess: "rw"
      hwaccess: "hro"
      fields: [
        { bits: "15:0",  resval: "64",   name: "cfg_trans_num",             desc: "Analog cfg trans number (including h, as the last one)" }
        { bits: "31:16", resval: "5",    name: "cycle_per_wwl_high",        desc: "Cycle per wwl high"                                     }
      ]
    }

    { name:     "counter_cfg_2"
      desc:     "Registers for counter configuration 2"
      swaccess: "rw"
      hwaccess: "hro"
      fields: [
        { bits: "15:0",  resval: "5",    name: "cycle_per_wwl_low",         desc: "Cycle per wwl low"                                      }
        { bits: "31:16", resval: "5",    name: "cycle_per_spin_write",      desc: "Cycle per spin write"                                   }
      ]
    }

    { name:     "counter_cfg_3"
      desc:     "Registers for counter configuration 3"
      swaccess: "rw"
      hwaccess: "hro"
      fields: [
        { bits: "15:0",  resval: "10",   name: "cycle_per_spin_compute",    desc: "Cycle per spin compute"                                 }
        { bits: "31:16", resval: "100",  name: "debug_cycle_per_spin_read", desc: "Cycle per debug spin read"                              }
      ]
    }

    { name:     "counter_cfg_4"
      desc:     "Registers for counter configuration 4"
      swaccess: "rw"
      hwaccess: "hro"
      fields: [
        { bits: "15:0",  resval: "1023", name: "debug_spin_read_num",       desc: "Cycle per debug spin read number"                       }
        { bits: "26:16", resval: "1024", name: "icon_last_raddr_plus_one",  desc: "Flip icon last address plus one"                        }
        { bits: "31:27", resval: "4",    name: "dgt_hscaling",              desc: "Scaling factor for dgt"                                 }
      ]
    }

    { multireg:
      { name:     "wwl_vdd_cfg"
        desc:     "wwl_vdd_cfg values"
        swaccess: "rw"
        hwaccess: "hro"
        count:    "8"
        cname:    "wwl_vdd_cfg"
        fields: [
          { bits: "31:0", resval: "0xFFFFFFFF", name: "wwl_vdd_cfg", desc: "wwl_vdd_cfg values" }
        ]
      }
    }

    { multireg:
      { name:     "wwl_vread_cfg"
        desc:     "wwl_vread_cfg values"
        swaccess: "rw"
        hwaccess: "hro"
        count:    "8"
        cname:    "wwl_vread_cfg"
        fields: [
          { bits: "31:0", resval: "0", name: "wwl_vread_cfg", desc: "wwl_vread_cfg values" }
        ]
      }
    }

    { multireg:
      { name:     "spin_wwl_strobe"
        desc:     "spin_wwl_strobe values"
        swaccess: "rw"
        hwaccess: "hro"
        count:    "8"
        cname:    "spin_wwl_strobe"
        fields: [
          { bits: "31:0", resval: "0xFFFFFFFF", name: "spin_wwl_strobe", desc: "spin_wwl_strobe values" }
        ]
      }
    }

    { multireg:
      { name:     "spin_feedback_cfg"
        desc:     "spin_feedback_cfg values"
        swaccess: "rw"
        hwaccess: "hro"
        count:    "8"
        cname:    "spin_feedback_cfg"
        fields: [
          { bits: "31:0", resval: "0xFFFFFFFF", name: "spin_feedback_cfg", desc: "spin_feedback_cfg values" }
        ]
      }
    }

    { multireg:
      { name:     "h_rdata"
        desc:     "h_rdata values"
        swaccess: "rw"
        hwaccess: "hro"
        count:    "32"
        cname:    "h_rdata"
        fields: [
          { bits: "31:0", resval: "0", name: "h_rdata", desc: "h_rdata values" }
        ]
      }
    }

    { multireg:
      { name:     "wbl_floating"
        desc:     "wbl_floating values"
        swaccess: "rw"
        hwaccess: "hro"
        count:    "32"
        cname:    "wbl_floating"
        fields: [
          { bits: "31:0", resval: "0", name: "wbl_floating", desc: "wbl_floating values" }
        ]
      }
    }

    { multireg:
      { name:     "debug_j_one_hot_wwl"
        desc:     "debug_j_one_hot_wwl values"
        swaccess: "rw"
        hwaccess: "hro"
        count:    "8"
        cname:    "debug_j_one_hot_wwl"
        fields: [
          { bits: "31:0", resval: "0", name: "debug_j_one_hot_wwl", desc: "debug_j_one_hot_wwl values" }
        ]
      }
    }

    { name:     "output_status"
      desc:     "Output status signals"
      swaccess: "rw"
      hwaccess: "hwo"
      fields: [
        { bits: "0",     resval: "1",  name: "dt_cfg_idle",                   desc: "Whether the analog config is in idle"                 }
        { bits: "1",     resval: "1",  name: "cmpt_idle",                     desc: "Whether the computation is in idle"                   }
        { bits: "2",     resval: "0",  name: "energy_fifo_update",            desc: "Whether the energy fifo is being updated"             }
        { bits: "3",     resval: "0",  name: "spin_fifo_update",              desc: "Whether the spin fifo is being updated"               }
        { bits: "4",     resval: "0",  name: "debug_j_read_data_valid",       desc: "Whether the debug J read data is valid"               }
        { bits: "5",     resval: "1",  name: "debug_analog_dt_w_idle",        desc: "Whether the debug analog dt w is idle"                }
        { bits: "6",     resval: "1",  name: "debug_analog_dt_r_idle",        desc: "Whether the debug analog dt r is idle"                }
        { bits: "7",     resval: "1",  name: "debug_spin_w_idle",             desc: "Whether the debug spin w is idle"                     }
        { bits: "8",     resval: "1",  name: "debug_spin_r_idle",             desc: "Whether the debug spin r is idle"                     }
        { bits: "9",     resval: "1",  name: "debug_spin_cmpt_idle",          desc: "Whether the debug spin computation is idle"           }
        { bits: "10",    resval: "0",  name: "debug_fm_upstream_handshake",   desc: "Whether the fm upstream handshake is on"              }
        { bits: "11",    resval: "0",  name: "debug_fm_downstream_handshake", desc: "Whether the fm downstream handshake is on"            }
        { bits: "12",    resval: "0",  name: "debug_aw_downstream_handshake", desc: "Whether the aw downstream handshake is on"            }
        { bits: "13",    resval: "0",  name: "debug_em_upstream_handshake",   desc: "Whether the em upstream handshake is on"              }
        { bits: "14",    resval: "0",  name: "multi_cmpt_mode_idle",          desc: "Whether the multi computation mode is idle"           }
      ]
    }

    { name:     "debug_fm_energy_input"
      desc:     "debug_fm_energy_input signals"
      swaccess: "rw"
      hwaccess: "hwo"
      fields: [
        { bits: "31:0",  resval: "0",  name: "debug_fm_energy_input",         desc: "Energy input to the fm"                               }
      ]
    }

    { name:     "energy_fifo_data_0"
      desc:     "Registers for energy fifo data 0"
      swaccess: "rw"
      hwaccess: "hwo"
      fields: [
        { bits: "31:0",  resval: "0",  name: "energy_fifo_0", desc: "Energy fifo data 0" }
      ]
    }

    { name:     "energy_fifo_data_1"
      desc:     "Registers for energy fifo data 1"
      swaccess: "rw"
      hwaccess: "hwo"
      fields: [
        { bits: "31:0", resval: "0",  name: "energy_fifo_1", desc: "Energy fifo data 1" }
      ]
    }

    { multireg:
      { name:     "spin_fifo_data_0"
        desc:     "spin_fifo_data_0 values"
        swaccess: "rw"
        hwaccess: "hwo"
        count:    "8"
        cname:    "spin_fifo_data_0"
        fields: [
          { bits: "31:0", resval: "0", name: "spin_fifo_data_0", desc: "spin_fifo_data_0 values" }
        ]
      }
    }

    { multireg:
      { name:     "spin_fifo_data_1"
        desc:     "spin_fifo_data_1 values"
        swaccess: "rw"
        hwaccess: "hwo"
        count:    "8"
        cname:    "spin_fifo_data_1"
        fields: [
          { bits: "31:0", resval: "0", name: "spin_fifo_data_1", desc: "spin_fifo_data_1 values" }
        ]
      }
    }

    { multireg:
      { name:     "debug_j_read_data"
        desc:     "debug_j_read_data values"
        swaccess: "rw"
        hwaccess: "hwo"
        count:    "32"
        cname:    "debug_j_read_data"
        fields: [
          { bits: "31:0", resval: "0", name: "debug_j_read_data", desc: "debug_j_read_data values" }
        ]
      }
    }

    { multireg:
      { name:     "debug_fm_spin_out"
        desc:     "debug_fm_spin_out values"
        swaccess: "rw"
        hwaccess: "hwo"
        count:    "8"
        cname:    "debug_fm_spin_out"
        fields: [
          { bits: "31:0", resval: "0", name: "debug_fm_spin_out", desc: "debug_fm_spin_out values" }
        ]
      }
    }

    { multireg:
      { name:     "debug_aw_spin_out"
        desc:     "debug_aw_spin_out values"
        swaccess: "rw"
        hwaccess: "hwo"
        count:    "8"
        cname:    "debug_aw_spin_out"
        fields: [
          { bits: "31:0", resval: "0", name: "debug_aw_spin_out", desc: "debug_aw_spin_out values" }
        ]
      }
    }

    { multireg:
      { name:     "debug_em_spin_in"
        desc:     "debug_em_spin_in values"
        swaccess: "rw"
        hwaccess: "hwo"
        count:    "8"
        cname:    "debug_em_spin_in"
        fields: [
          { bits: "31:0", resval: "0", name: "debug_em_spin_in", desc: "debug_em_spin_in values" }
        ]
      }
    }

    { name:     "cmpt_idx"
      desc:     "Registers for cmpt index"
      swaccess: "rw"
      hwaccess: "hwo"
      fields: [
        { bits: "31:0", resval: "0",  name: "cmpt_idx", desc: "cmpt index q" }
      ]
    }

    { name:     "cycle_per_iteration"
      desc:     "Registers for cycle per iteration"
      swaccess: "rw"
      hwaccess: "hwo"
      fields: [
        { bits: "31:0", resval: "0",  name: "cycle_per_iteration", desc: "cycle per iteration" }
      ]
    }

    { name:     "cycle_per_cmpt"
      desc:     "Registers for cycle per cmpt"
      swaccess: "rw"
      hwaccess: "hwo"
      fields: [
        { bits: "31:0", resval: "0",  name: "cycle_per_cmpt", desc: "cycle per cmpt" }
      ]
    }

    { name:     "cycle_all_cmpt_lsb"
      desc:     "Registers for cycle all cmpt LSB"
      swaccess: "rw"
      hwaccess: "hwo"
      fields: [
        { bits: "31:0", resval: "0",  name: "cycle_all_cmpt_lsb", desc: "cycle all cmpt LSB" }
      ]
    }

    { name:     "cycle_all_cmpt_msb"
      desc:     "Registers for cycle all cmpt MSB"
      swaccess: "rw"
      hwaccess: "hwo"
      fields: [
        { bits: "31:0", resval: "0",  name: "cycle_all_cmpt_msb", desc: "cycle all cmpt MSB" }
      ]
    }

    { name:     "flip_mem_ren_raddr"
      desc:     "Registers for flip memory read enable and read address"
      swaccess: "rw"
      hwaccess: "hwo"
      fields: [
        { bits: "0",     resval: "0",  name: "debug_spin_valid", desc: "Whether flip memory is used by spin debugging mode" }
        { bits: "1",     resval: "1",  name: "flip_q_valid",     desc: "Whether flip memory is valid"                       }
        { bits: "11:2",  resval: "0",  name: "flip_raddr",       desc: "Flip memory read address from flip manager"         }
        { bits: "21:12", resval: "0",  name: "debug_spin_waddr", desc: "Flip memory write address from spin debugging mode" }
      ]
    }

    { name:     "j_mem_ren_raddr"
      desc:     "Registers for J memory read enable and read address"
      swaccess: "rw"
      hwaccess: "hwo"
      fields: [
        { bits: "0",     resval: "0",  name: "j_mem_ren_load",   desc: "Whether J memory is used by analog cfg module"   }
        { bits: "1",     resval: "1",  name: "dgt_weight_ren",   desc: "Whether J memory is used by energy monitor"      }
        { bits: "7:2",   resval: "0",  name: "j_raddr_load",     desc: "J memory read address from analog cfg module"    }
        { bits: "13:8",  resval: "0",  name: "dgt_weight_raddr", desc: "J memory write address from energy monitor"      }
      ]
    }

  ]
}
