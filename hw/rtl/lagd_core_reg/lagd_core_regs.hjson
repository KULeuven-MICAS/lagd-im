// Copyright 2025 KU Leuven.
// Licensed under the Apache License, Version 2.0, see LICENSE for details.
// SPDX-License-Identifier: Apache-2.0

// Author: Jiacong Sun <jiacong.sun@kuleuven.be>

{
  name: "lagd_core"
  clock_primary: "clk_i"
  bus_interfaces: [
    { protocol: "reg_iface", direction: "device" }
  ],
  regwidth: 64
  registers: [

    { name:     "global_cfg"
      desc:     "Global configuration signals"
      swaccess: "rw"
      hwaccess: "hro"
      fields: [
        { bits: "0",  name: "flush_en",                                  desc: "Whether to flush data"                                 }
        { bits: "1",  name: "en_aw",                                     desc: "Whether to enable the analog macro wrap"               }
        { bits: "2",  name: "en_em",                                     desc: "Whether to enable the energy monitor"                  }
        { bits: "3",  name: "en_fm",                                     desc: "Whether to enable the flip manager"                    }
        { bits: "4",  name: "en_ff",                                     desc: "Whether to enable the flip filter"                     }
        { bits: "5",  name: "en_ef",                                     desc: "Whether to enable the energy monitor fifo"             }
        { bits: "6",  name: "en_analog_loop",                            desc: "Whether to include analog in the loop"                 }
        { bits: "7",  name: "en_comparison",                             desc: "Whether to enable energy comparison"                   }
        { bits: "8",  name: "cmpt_en",                                   desc: "Whether to start computation"                          }
        { bits: "9",  name: "config_valid_aw",                           desc: "Whether to enable configuration for analog wrap"       }
        { bits: "10", name: "config_valid_em",                           desc: "Whether to enable configuration for energy monitor"    }
        { bits: "11", name: "config_valid_fm",                           desc: "Whether to enable configuration for flip manager"      }
        { bits: "12", name: "debug_dt_configure_enable",                 desc: "Whether to enable configuration for debug dt module"   }
        { bits: "13", name: "debug_spin_configure_enable",               desc: "Whether to enable configuration for debug spin module" }
        { bits: "14", name: "config_spin_initial_skip",                  desc: "Whether to skip current spin initial value"            }
        { bits: "15", name: "bypass_data_conversion",                    desc: "Whether to skip analog data conversion"                }
        { bits: "16", name: "dt_cfg_enable",                             desc: "Whether to start analog weight onloading"              }
        { bits: "17", name: "host_readout",                              desc: "Whether to read spins from spin pop interface"         }
        { bits: "18", name: "flip_disable",                              desc: "Whether to disable applying flip icons"                }
        { bits: "19", name: "enable_flip_detection",                     desc: "Whether to enable flip detection"                      }
        { bits: "20", name: "debug_j_write_en",                          desc: "Whether to enable debug J writing mode"                }
        { bits: "21", name: "debug_j_read_en",                           desc: "Whether to enable debug J reading mode"                }
        { bits: "22", name: "debug_spin_write_en",                       desc: "Whether to enable debug spin writing mode"             }
        { bits: "23", name: "debug_spin_compute_en",                     desc: "Whether to enable debug spin computing mode"           }
        { bits: "24", name: "debug_spin_read_en",                        desc: "Whether to enable debug spin reading mode"             }
        { bits: "32:25", resval: "0", name: "config_counter",            desc: "Number of spins"                                       }
        { bits: "33", name: "wwl_vdd_cfg_256",                           desc: "wwl_vdd_cfg [256]"                                     }
        { bits: "34", name: "wwl_vread_cfg_256",                         desc: "wwl_vread_cfg [256]"                                   }
        { bits: "36:35", resval: "0", name: "synchronizer_pipe_num",     desc: "Selected synchronizer num"                             }
        { bits: "38:37", resval: "0", name: "synchronizer_wbl_pipe_num", desc: "Selected synchronizer num for wbl read"                }
        { bits: "39", name: "debug_h_wwl",                               desc: "h_wwl in debug dt write/read mode"                     }
        { bits: "45:40", resval: "0", name: "dgt_addr_upper_bound",      desc: "J address upper bound (inclusive)"                     }
        { bits: "46", name: "ctnus_fifo_read",                           desc: "Whether to read energy/spin fifo continuously"         }
      ]
    }

    { multireg:
      { name:     "config_spin_initial"
        desc:     "Registers for setting initial spin values"
        swaccess: "rw"
        hwaccess: "hro"
        count:    "4"
        cname:    "config_spin_initial"
        fields: [
          { bits: "63:0", resval: "0", name: "config_spin_initial", desc: "Registers for setting initial spin values" }
        ]
      }
    }

    { name:     "counter_cfg_1"
      desc:     "Registers for counter configuration 1"
      swaccess: "rw"
      hwaccess: "hro"
      fields: [
        { bits: "15:0", resval: "0", name: "cfg_trans_num", desc: "Analog cfg trans number (including h, as the last one)" }
        { bits: "31:16", resval: "0", name: "cycle_per_wwl_high", desc: "Cycle per wwl high" }
        { bits: "47:32", resval: "0", name: "cycle_per_wwl_low", desc: "Cycle per wwl low" }
        { bits: "63:48", resval: "0", name: "cycle_per_spin_write", desc: "Cycle per spin write" }
      ]
    }

    { name:     "counter_cfg_2"
      desc:     "Registers for counter configuration 2"
      swaccess: "rw"
      hwaccess: "hro"
      fields: [
        { bits: "15:0", resval: "0", name: "cycle_per_spin_compute", desc: "Cycle per spin compute" }
        { bits: "31:16", resval: "0", name: "debug_cycle_per_spin_read", desc: "Cycle per debug spin read" }
        { bits: "47:32", resval: "0", name: "debug_spin_read_num", desc: "Cycle per debug spin read number" }
        { bits: "58:48", resval: "0", name: "icon_last_raddr_plus_one", desc: "Flip icon last address plus one" }
        { bits: "63:59", resval: "0", name: "dgt_hscaling", desc: "Scaling factor for dgt" }
      ]
    }

    { multireg:
      { name:     "wwl_vdd_cfg"
        desc:     "wwl_vdd_cfg values"
        swaccess: "rw"
        hwaccess: "hro"
        count:    "4"
        cname:    "wwl_vdd_cfg"
        fields: [
          { bits: "63:0", resval: "0", name: "wwl_vdd_cfg", desc: "wwl_vdd_cfg values" }
        ]
      }
    }

    { multireg:
      { name:     "wwl_vread_cfg"
        desc:     "wwl_vread_cfg values"
        swaccess: "rw"
        hwaccess: "hro"
        count:    "4"
        cname:    "wwl_vread_cfg"
        fields: [
          { bits: "63:0", resval: "0", name: "wwl_vread_cfg", desc: "wwl_vread_cfg values" }
        ]
      }
    }

    { multireg:
      { name:     "spin_wwl_strobe"
        desc:     "spin_wwl_strobe values"
        swaccess: "rw"
        hwaccess: "hro"
        count:    "4"
        cname:    "spin_wwl_strobe"
        fields: [
          { bits: "63:0", resval: "0", name: "spin_wwl_strobe", desc: "spin_wwl_strobe values" }
        ]
      }
    }

    { multireg:
      { name:     "spin_feedback_cfg"
        desc:     "spin_feedback_cfg values"
        swaccess: "rw"
        hwaccess: "hro"
        count:    "4"
        cname:    "spin_feedback_cfg"
        fields: [
          { bits: "63:0", resval: "0", name: "spin_feedback_cfg", desc: "spin_feedback_cfg values" }
        ]
      }
    }

    { multireg:
      { name:     "h_rdata"
        desc:     "h_rdata values"
        swaccess: "rw"
        hwaccess: "hro"
        count:    "16"
        cname:    "h_rdata"
        fields: [
          { bits: "63:0", resval: "0", name: "h_rdata", desc: "h_rdata values" }
        ]
      }
    }

    { multireg:
      { name:     "wbl_floating"
        desc:     "wbl_floating values"
        swaccess: "rw"
        hwaccess: "hro"
        count:    "16"
        cname:    "wbl_floating"
        fields: [
          { bits: "63:0", resval: "0", name: "wbl_floating", desc: "wbl_floating values" }
        ]
      }
    }

    { multireg:
      { name:     "debug_j_one_hot_wwl"
        desc:     "debug_j_one_hot_wwl values"
        swaccess: "rw"
        hwaccess: "hro"
        count:    "4"
        cname:    "debug_j_one_hot_wwl"
        fields: [
          { bits: "63:0", resval: "0", name: "debug_j_one_hot_wwl", desc: "debug_j_one_hot_wwl values" }
        ]
      }
    }

    { name:     "output_status"
      desc:     "Output status signals"
      swaccess: "rw"
      hwaccess: "hwo"
      fields: [
        { bits: "0",  name: "dt_cfg_idle",                 desc: "Whether the analog config is in idle"                  }
        { bits: "1",  name: "cmpt_idle",                   desc: "Whether the computation is in idle"                    }
        { bits: "2",  name: "energy_fifo_update",          desc: "Whether the energy fifo is being updated"              }
        { bits: "3",  name: "spin_fifo_update",            desc: "Whether the spin fifo is being updated"                }
        { bits: "4",  name: "debug_j_read_data_valid",     desc: "Whether the debug J read data is valid"                }
        { bits: "5",  name: "debug_analog_dt_w_idle",      desc: "Whether the debug analog dt w is idle"                 }
        { bits: "6",  name: "debug_analog_dt_r_idle",      desc: "Whether the debug analog dt r is idle"                 }
        { bits: "7",  name: "debug_spin_w_idle",           desc: "Whether the debug spin w is idle"                      }
        { bits: "8",  name: "debug_spin_r_idle",           desc: "Whether the debug spin r is idle"                      }
        { bits: "9",  name: "debug_spin_cmpt_idle",        desc: "Whether the debug spin computation is idle"            }
      ]
    }

    { name:     "energy_fifo_data"
      desc:     "Registers for energy fifo data"
      swaccess: "rw"
      hwaccess: "hwo"
      fields: [
        { bits: "31:0", resval: "0",  name: "energy_fifo_0", desc: "Energy fifo data 0" }
        { bits: "63:32", resval: "0", name: "energy_fifo_1", desc: "Energy fifo data 1" }
      ]
    }

    { multireg:
      { name:     "spin_fifo_data_0"
        desc:     "spin_fifo_data_0 values"
        swaccess: "rw"
        hwaccess: "hwo"
        count:    "4"
        cname:    "spin_fifo_data_0"
        fields: [
          { bits: "63:0", resval: "0", name: "spin_fifo_data_0", desc: "spin_fifo_data_0 values" }
        ]
      }
    }

    { multireg:
      { name:     "spin_fifo_data_1"
        desc:     "spin_fifo_data_1 values"
        swaccess: "rw"
        hwaccess: "hwo"
        count:    "4"
        cname:    "spin_fifo_data_1"
        fields: [
          { bits: "63:0", resval: "0", name: "spin_fifo_data_1", desc: "spin_fifo_data_1 values" }
        ]
      }
    }

    { multireg:
      { name:     "debug_j_read_data"
        desc:     "debug_j_read_data values"
        swaccess: "rw"
        hwaccess: "hro"
        count:    "16"
        cname:    "debug_j_read_data"
        fields: [
          { bits: "63:0", resval: "0", name: "debug_j_read_data", desc: "debug_j_read_data values" }
        ]
      }
    }

  ]
}
